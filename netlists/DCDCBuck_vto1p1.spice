** sch_path: /foss/designs/power_mosfet/dos/DCDCBuck_vto1p1.sch
.subckt DCDCBuck_vto1p1 Vo Vi Vs
*.PININFO Vo:B Vi:B Vs:B
MM2 Vo Vi Vs Vs sg13_hv_nmos w=10u l=0.45u ng=1 m=200
.ends
